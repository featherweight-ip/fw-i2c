// Register map of the freecores 'i2c' core (OpenCores I2C-Master,
// R. Herveille, with the 2013 slave-mode extension by H. Baier), as
// implemented by rtl/verilog/i2c_master_top.v at freecores/i2c 3b067f0.
//
// This describes the RTL as built, not the 2003 PDF specification. Where
// the two differ, the description says so; see docs/reference/deviations.md.
//
// Bus: 8-bit WISHBONE Classic, wb_adr_i[2:0], one register per byte address.
// Registers at 0x3 and 0x4 are split: a write reaches one register (TXR,
// CR) and a read returns another (RXR, SR).

addrmap oc_i2c_master {
    name = "freecores i2c core";
    desc = "Register map of the freecores i2c core (OpenCores I2C-Master with
            the slave-mode extension), as implemented at freecores/i2c 3b067f0.";

    default regwidth = 8;
    default accesswidth = 8;
    default sw = rw;
    default hw = r;

    reg {
        name = "Clock Prescale, low byte (PRERlo)";
        desc = "Bits [7:0] of the 16-bit prescale value PRER. See PRERhi.";
        field {
            desc = "Prescale value bits [7:0].";
        } PRER_LO[7:0] = 8'hFF;
    } PRERlo @ 0x0;

    reg {
        name = "Clock Prescale, high byte (PRERhi)";
        desc = "Bits [15:8] of the 16-bit prescale value PRER.

The bit controller's clock divider reloads from PRER and produces one
clock enable every PRER+1 cycles of wb_clk_i. A data bit takes five enables,
so nominally PRER = f(wb_clk_i) / (5 * f(SCL)) - 1, as the PDF specification
says. The real SCL is somewhat slower: the divider pauses after every SCL
release until the filtered SCL input reads high (see the timing page).
PRER[15:2] also sets the input glitch-filter sample rate.

PRER must be at least 1. Change PRER only while CTR.EN is 0; writes are not
blocked when EN is 1.";
        field {
            desc = "Prescale value bits [15:8].";
        } PRER_HI[7:0] = 8'hFF;
    } PRERhi @ 0x1;

    reg {
        name = "Control (CTR)";
        desc = "All eight bits are stored and read back, including the bits
the PDF specification lists as reserved.";
        field {
            name = "Core enable";
            desc = "1: the core is enabled. 0: the core is disabled, and the
CR register ignores writes. Clearing EN in the middle of a transfer can
leave the I2C bus hung.";
        } EN[7:7] = 0;
        field {
            name = "Interrupt enable";
            desc = "1: wb_inta_o follows SR.IF. 0: wb_inta_o is held low;
SR.IF still sets and can be polled.";
        } IEN[6:6] = 0;
        field {
            name = "Slave enable";
            desc = "Slave-mode extension. 1: the core responds as a slave when
the 7-bit address sent after a START matches SLADR. The PDF specification
lists this bit as reserved.";
        } SLV_EN[5:5] = 0;
        field {
            name = "Reserved";
            desc = "Stored and read back; no function.";
        } RSVD[4:0] = 0;
    } CTR @ 0x2;

    reg {
        name = "Transmit (TXR)";
        desc = "Next byte to transmit. For a slave address byte, bit 0 is the
R/W bit (1 = read from slave). In slave mode, writing CR.SL_CONT loads TXR
into the shift register, so TXR holds the byte to send to a master that is
reading. TXR can be read back at 0x5 (TXR_DBG).";
        field {
            sw = w;
            desc = "Byte to transmit.";
        } DATA[7:0] = 0;
    } TXR @ 0x3;

    reg {
        name = "Receive (RXR)";
        desc = "The byte-controller shift register. After a read command it
holds the last byte received. It is the same register that shifts TXR out,
so its contents change during every transfer, not only reads. In slave mode
it is overwritten by the received address byte, and writing CR.SL_CONT
overwrites it with TXR, so read RXR before writing SL_CONT.";
        field {
            sw = r; hw = w;
            desc = "Shift register contents.";
        } DATA[7:0] = 0;
    } RXR @ 0x3;

    reg {
        name = "Command (CR)";
        desc = "Commands to the byte controller. CR is written only while
CTR.EN is 1. STA, STO, RD and WR stay set until the command completes or
arbitration is lost, then clear together. IACK and SL_CONT clear on the
next clock. ACK is not cleared. CR can be read back at 0x6 (CR_DBG).

A transfer starts only when RD, WR or STO is set: STA alone does nothing.
STA with RD or WR sends a (repeated) START, then the byte. RD or WR with
STO sends the byte, its acknowledge, then a STOP. STA with STO (and no RD
or WR) is not a bare START+STOP: it sends START, writes TXR, then STOP.";
        field {
            sw = w; hwclr;
            name = "Start";
            desc = "Generate a START (or repeated START) before the byte.";
        } STA[7:7] = 0;
        field {
            sw = w; hwclr;
            name = "Stop";
            desc = "Generate a STOP after the byte, or on its own if RD and
WR are clear.";
        } STO[6:6] = 0;
        field {
            sw = w; hwclr;
            name = "Read";
            desc = "Read a byte from the slave.";
        } RD[5:5] = 0;
        field {
            sw = w; hwclr;
            name = "Write";
            desc = "Write TXR to the slave.";
        } WR[4:4] = 0;
        field {
            sw = w;
            name = "Acknowledge";
            desc = "Acknowledge to send after a byte the master reads:
0 = ACK, 1 = NACK. Ignored in slave mode, where the core always ACKs.
This bit holds its value until the next CR write.";
        } ACK[3:3] = 0;
        field {
            sw = w; singlepulse;
            name = "Reserved";
            desc = "Cleared on the next clock.";
        } RSVD[2:2] = 0;
        field {
            sw = w; singlepulse;
            name = "Slave continue";
            desc = "Slave-mode extension. Releases SCL after a slave byte and
loads TXR into the shift register. The PDF specification lists this bit
as reserved.";
        } SL_CONT[1:1] = 0;
        field {
            sw = w; singlepulse;
            name = "Interrupt acknowledge";
            desc = "Clears SR.IF. A level source (SR.SLV_DAT_REQ or
SR.SLV_DAT_AVAIL) still set sets IF again on the next clock.";
        } IACK[0:0] = 0;
    } CR @ 0x4;

    reg {
        name = "Status (SR)";
        field {
            sw = r; hw = w;
            name = "Received acknowledge";
            desc = "Acknowledge bit seen in the last ACK slot: 0 = ACK,
1 = NACK. In slave-transmit mode it is the master's acknowledge.";
        } RXACK[7:7] = 0;
        field {
            sw = r; hw = w;
            name = "Bus busy";
            desc = "1 after a START is detected on the bus, 0 after a STOP.
Tracks any master, not only this core, and keeps tracking while EN is
0. Cleared only by reset or a detected STOP; there is no bus-idle timeout.";
        } BUSY[6:6] = 0;
        field {
            sw = r; hw = w;
            name = "Arbitration lost";
            desc = "Set when the core loses arbitration: during a WRITE bit
(address, data, or a NACK it sends) it releases SDA and samples 0 while SCL
is high, or it sees a STOP while a command other than STOP is in progress.
Not checked during START, repeated START, STOP or received bits. Losing
arbitration clears the command bits, returns the byte controller to idle
and sets IF. AL stays set until a CR write with STA set.";
        } AL[5:5] = 0;
        field {
            sw = r; hw = w;
            name = "Slave mode";
            desc = "Slave-mode extension; reserved (0) in the PDF
specification. Meant to show that the core was addressed as a slave. It is
updated only when a master command completes, when the slave-active flag is
always 0, so in practice it reads 0. To be confirmed by simulation.";
        } SLV_MODE[4:4] = 0;
        field {
            sw = r; hw = w;
            name = "Slave data available";
            desc = "Slave-mode extension. A master wrote a byte to this core
(or addressed it for writing). The byte is in RXR and SCL is held low. Stays
set, and keeps SR.IF set, until CR.SL_CONT is written.";
        } SLV_DAT_AVAIL[3:3] = 0;
        field {
            sw = r; hw = w;
            name = "Slave data request";
            desc = "Slave-mode extension. A master is reading from this core
and SCL is held low. Write the next byte to TXR, then write CR.SL_CONT. Stays
set, and keeps SR.IF set, until SL_CONT.";
        } SLV_DAT_REQ[2:2] = 0;
        field {
            sw = r; hw = w;
            name = "Transfer in progress";
            desc = "Registered copy of CR.RD | CR.WR, so it lags those bits by
one clock. Not set by a STA-only or STO-only command.";
        } TIP[1:1] = 0;
        field {
            sw = r; hw = w;
            name = "Interrupt flag";
            desc = "Set when a master command completes, arbitration is lost,
a slave byte completes, or SLV_DAT_REQ/SLV_DAT_AVAIL is set. Cleared by
CR.IACK. Drives wb_inta_o when CTR.IEN is 1.";
        } IF[0:0] = 0;
    } SR @ 0x4;

    reg {
        name = "Transmit readback (TXR_DBG)";
        desc = "Read-only copy of TXR. Undocumented in the PDF specification;
the upstream testbench names it TXR_R. Writes are ignored.";
        field {
            sw = r; hw = w;
            desc = "TXR contents.";
        } DATA[7:0] = 0;
    } TXR_DBG @ 0x5;

    reg {
        name = "Command readback (CR_DBG)";
        desc = "Read-only copy of CR. Undocumented in the PDF specification.
Shows the command bits still pending and the stored ACK bit. Writes are
ignored.";
        field {
            sw = r; hw = w;
            desc = "CR contents.";
        } DATA[7:0] = 0;
    } CR_DBG @ 0x6;

    reg {
        name = "Slave address (SLADR)";
        desc = "Slave-mode extension; reserved (reads 0) in the original core.
The 7-bit address this core answers to when CTR.SLV_EN is 1. The reset value
comes from the DEFAULT_SLAVE_ADDR parameter (default 7'h7E). Only 7-bit
addresses are supported; the general-call address is not recognized.";
        field {
            name = "Slave address";
        } ADDR[6:0] = 7'h7E;
        field {
            sw = r; hw = na;
            desc = "Reads 0.";
        } RSVD[7:7] = 0;
    } SLADR @ 0x7;
};

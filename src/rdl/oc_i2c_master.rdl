// Register map of the OpenCores I2C-Master core (R. Herveille) as
// implemented by rtl/verilog/i2c_master_top.v at freecores/i2c dba90b2
// ("R76": OpenCores SVN rev 76, the last master-only RTL).
//
// This describes the RTL as built, not the 2003 PDF specification. Where
// the two differ, the description says so; see docs/reference/deviations.md.
//
// Bus: 8-bit WISHBONE Classic, wb_adr_i[2:0], one register per byte address.
// Registers at 0x3 and 0x4 are split: a write reaches one register (TXR,
// CR) and a read returns another (RXR, SR).

addrmap oc_i2c_master {
    name = "OpenCores I2C-Master (R76)";
    desc = "Register map of the OpenCores I2C-Master core as implemented at
            freecores/i2c dba90b2 (OpenCores SVN rev 76).";

    default regwidth = 8;
    default accesswidth = 8;
    default sw = rw;
    default hw = r;

    reg {
        name = "Clock Prescale, low byte (PRERlo)";
        desc = "Bits [7:0] of the 16-bit prescale value PRER. See PRERhi.";
        field {
            desc = "Prescale value bits [7:0].";
        } PRER_LO[7:0] = 8'hFF;
    } PRERlo @ 0x0;

    reg {
        name = "Clock Prescale, high byte (PRERhi)";
        desc = "Bits [15:8] of the 16-bit prescale value PRER.

The bit controller's clock divider reloads from PRER and produces one
clock enable every PRER+1 cycles of wb_clk_i. A data bit takes five enables,
so nominally PRER = f(wb_clk_i) / (5 * f(SCL)) - 1, as the PDF specification
says. The real SCL is somewhat slower: the divider pauses after every SCL
release until the filtered SCL input reads high (see the timing page).
PRER[15:2] also sets the input glitch-filter sample rate.

PRER must be at least 2 (see D7). Change PRER only while CTR.EN is 0; writes are not
blocked when EN is 1.";
        field {
            desc = "Prescale value bits [15:8].";
        } PRER_HI[7:0] = 8'hFF;
    } PRERhi @ 0x1;

    reg {
        name = "Control (CTR)";
        desc = "All eight bits are stored and read back, including the bits
the PDF specification lists as reserved.";
        field {
            name = "Core enable";
            desc = "1: the core is enabled. 0: the core is disabled, and the
CR register ignores writes. Clearing EN in the middle of a transfer can
leave the I2C bus hung.";
        } EN[7:7] = 0;
        field {
            name = "Interrupt enable";
            desc = "1: wb_inta_o follows SR.IF. 0: wb_inta_o is held low;
SR.IF still sets and can be polled.";
        } IEN[6:6] = 0;
        field {
            name = "Reserved";
            desc = "Stored and read back; no function.";
        } RSVD[5:0] = 0;
    } CTR @ 0x2;

    reg {
        name = "Transmit (TXR)";
        desc = "Next byte to transmit. For a slave address byte, bit 0 is the
R/W bit (1 = read from slave). TXR is loaded into the shift register when
a command starts. It can be read back at 0x5 (TXR_DBG).";
        field {
            sw = w;
            desc = "Byte to transmit.";
        } DATA[7:0] = 0;
    } TXR @ 0x3;

    reg {
        name = "Receive (RXR)";
        desc = "The byte-controller shift register. After a read command it
holds the last byte received. It is the same register that shifts TXR out,
so its contents change during every transfer, not only reads.";
        field {
            sw = r; hw = w;
            desc = "Shift register contents.";
        } DATA[7:0] = 0;
    } RXR @ 0x3;

    reg {
        name = "Command (CR)";
        desc = "Commands to the byte controller. CR is written only while
CTR.EN is 1. STA, STO, RD and WR stay set until the command completes or
arbitration is lost, then clear together. IACK and the reserved bits 2:1
clear on the next clock. ACK is not cleared. CR can be read back at 0x6
(CR_DBG).

A transfer starts only when RD, WR or STO is set: STA alone does nothing.
STA with RD or WR sends a (repeated) START, then the byte. RD or WR with
STO sends the byte, its acknowledge, then a STOP. STA with STO (and no RD
or WR) is not a bare START+STOP: it sends START, writes TXR, then STOP.";
        field {
            sw = w; hwclr;
            name = "Start";
            desc = "Generate a START (or repeated START) before the byte.";
        } STA[7:7] = 0;
        field {
            sw = w; hwclr;
            name = "Stop";
            desc = "Generate a STOP after the byte, or on its own if RD and
WR are clear.";
        } STO[6:6] = 0;
        field {
            sw = w; hwclr;
            name = "Read";
            desc = "Read a byte from the slave.";
        } RD[5:5] = 0;
        field {
            sw = w; hwclr;
            name = "Write";
            desc = "Write TXR to the slave.";
        } WR[4:4] = 0;
        field {
            sw = w;
            name = "Acknowledge";
            desc = "Acknowledge to send after a byte the master reads:
0 = ACK, 1 = NACK. This bit holds its value until the next CR write.";
        } ACK[3:3] = 0;
        field {
            sw = w; singlepulse;
            name = "Reserved";
            desc = "Cleared on the next clock.";
        } RSVD2[2:2] = 0;
        field {
            sw = w; singlepulse;
            name = "Reserved";
            desc = "Cleared on the next clock.";
        } RSVD1[1:1] = 0;
        field {
            sw = w; singlepulse;
            name = "Interrupt acknowledge";
            desc = "Clears SR.IF. IACK wins over a completion in the same
clock.";
        } IACK[0:0] = 0;
    } CR @ 0x4;

    reg {
        name = "Status (SR)";
        field {
            sw = r; hw = w;
            name = "Received acknowledge";
            desc = "The bit sampled in the last ACK slot: 0 = ACK, 1 = NACK.
After a write it is the slave's acknowledge. After a read it is the
acknowledge bit the core itself sent (CR.ACK).";
        } RXACK[7:7] = 0;
        field {
            sw = r; hw = w;
            name = "Bus busy";
            desc = "1 after a START is detected on the bus, 0 after a STOP.
Tracks any master, not only this core, and keeps tracking while EN is
0. Cleared only by reset or a detected STOP; there is no bus-idle timeout.";
        } BUSY[6:6] = 0;
        field {
            sw = r; hw = w;
            name = "Arbitration lost";
            desc = "Set when the core loses arbitration: during a WRITE bit
(address, data, or a NACK it sends) it releases SDA and samples 0 while SCL
is high, or it sees a STOP while a command other than STOP is in progress.
Not checked during START, repeated START, STOP or received bits. Losing
arbitration clears the command bits, returns the byte controller to idle
and sets IF. AL stays set until a CR write with STA set.";
        } AL[5:5] = 0;
        field {
            sw = r; hw = na;
            name = "Reserved";
            desc = "Reads 0.";
        } RSVD[4:2] = 0;
        field {
            sw = r; hw = w;
            name = "Transfer in progress";
            desc = "Registered copy of CR.RD | CR.WR, so it lags those bits by
one clock. Not set by a STA-only or STO-only command.";
        } TIP[1:1] = 0;
        field {
            sw = r; hw = w;
            name = "Interrupt flag";
            desc = "Set when a command completes or arbitration is lost.
Cleared by CR.IACK. Drives wb_inta_o when CTR.IEN is 1.";
        } IF[0:0] = 0;
    } SR @ 0x4;

    reg {
        name = "Transmit readback (TXR_DBG)";
        desc = "Read-only copy of TXR. Undocumented in the PDF specification;
the upstream testbench names it TXR_R. Writes are ignored.";
        field {
            sw = r; hw = w;
            desc = "TXR contents.";
        } DATA[7:0] = 0;
    } TXR_DBG @ 0x5;

    reg {
        name = "Command readback (CR_DBG)";
        desc = "Read-only copy of CR. Undocumented in the PDF specification.
Shows the command bits still pending and the stored ACK bit. Writes are
ignored.";
        field {
            sw = r; hw = w;
            desc = "CR contents.";
        } DATA[7:0] = 0;
    } CR_DBG @ 0x6;

    reg {
        name = "Reserved (0x7)";
        desc = "Reads 0; writes are ignored.";
        field {
            sw = r; hw = na;
            desc = "Reads 0.";
        } RSVD[7:0] = 0;
    } RSVD7 @ 0x7;
};
